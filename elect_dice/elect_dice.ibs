| / 7\'7
| \ \   Xilinx Inc.
| / /
| \_\/.\   IBIS Models for Spartan-3A
[IBIS ver]   3.2
[File name]   elect_dice.ibs
[File Rev]   2.3
[Date]   Wed May 25 03:11:06 2016
[Source]   HSPICE simulations
[Notes]   IBIS models for Spartan-3A Platform
[Disclaimer]
|   The data in this model is derived from SPICE simulations using
|   modeling information extracted from the target process. While
|   a great deal of care has been taken to provide information
|   that is accurate, this model is considered preliminary as it
|   has not been verified by actual silicon measurement. Treat the
|   data in this model as preliminary until actual silicon
|   verification is performed.
|   To accurately model package parasitics, please follow the
|   instructions at:  http://www.xilinx.com/xlnx/
|   xil_ans_display.jsp?getPagePath=11754
|   LVDS and LVPECL drivers require the use of external
|   termination resistors to provide the correct voltage levels.
|   For more information, refer to the Spartan-3 documentation.
|   NOTE: This file is compliant with IBIS Version 3.2, but it
|   may not implement all approved 3.2 features.
|   NOTE:  Newer versions of the buffer models may be available.
|   Check the web (http://www.xilinx.com/support/sw_ibis.htm) for
|   the latest file revision.  However, please be aware that the
|   web files are not compatible for use with IBISWriter, and
|   must be manually annotated, should their use be preferred.
[Copyright]
| Copyright 2006, Xilinx Inc., All rights reserved
|   Component Spartan-3A
[Component]   Spartan-3A
[Manufacturer]   Xilinx Inc.
[Package]
| For Package Type fg400
| variable   typ   min   max
R_pkg   272.32m   152.26m   332.89m
L_pkg   5.65nH   2.93nH   8.03nH
C_pkg   1.24pF   0.61pF   2.76pF
[Pin]  signal_name   model_name
Y7   DICE<0>   LVCMOS25_S_12_TB_25
Y9   DICE<1>   LVCMOS25_S_12_TB_25
W9   DICE<2>   LVCMOS25_S_12_TB_25
W10   DICE<3>   LVCMOS25_S_12_TB_25
Y11   DICE<4>   LVCMOS25_S_12_TB_25
U9   DICE<5>   LVCMOS25_S_12_TB_25
D1   Q<0>   LVCMOS25_S_12_LR_25
R13   DICE<6>   LVCMOS25_S_12_TB_25
E1   Q<1>   LVCMOS25_S_12_LR_25
C1   Q<2>   LVCMOS25_S_12_LR_25
E11   CLK   LVCMOS25_S_12_TB_25
M7   RESET   LVCMOS25_S_12_TB_25
F5   TDI   LVCMOS25_S_12_TB_25
E4   TMS   LVCMOS25_S_12_TB_25
D4   IO_L01P_3   NC
D3   IO_L01N_3   NC
B1   IO_L02P_3   NC
C2   IO_L02N_3   NC
D2   IO_L03N_3   NC
G7   IP_L04P_3   NC
G6   IP_L04N_3/VREF_3   NC
F4   IO_L06P_3   NC
G5   IO_L06N_3   NC
J6   IO_L07P_3   NC
J5   IO_L07N_3   NC
H7   3   NC
H6   IO_L08P_3   NC
H4   IO_L08N_3   NC
F3   IO_L09P_3   NC
G4   IO_L09N_3   NC
E3   IO_L10P_3   NC
F2   IO_L10N_3   NC
J8   IP_L11P_3   NC
J7   IP_L11N_3/VREF_3   NC
G3   IO_L12P_3   NC
H2   IO_L12N_3   NC
F1   IO_L13P_3   NC
G1   IO_L13N_3/VREF_3   NC
J4   IO_L14P_3   NC
H3   IO_L14N_3   NC
K8   IP_L15P_3   NC
K7   IP_L15N_3   NC
J3   IO_L16P_3   NC
J2   IO_L16N_3   NC
J1   LHCLK0   NC
K2   LHCLK1   NC
K3   LHCLK2   NC
L3   IRDY2/LHCLK3   NC
K6   IP_L19P_3   NC
K5   IP_L19N_3   NC
K4   LHCLK4   NC
L5   LHCLK5   NC
L1   TRDY2/LHCLK6   NC
M1   LHCLK7   NC
M2   IO_L22P_3/VREF_3   NC
M3   IO_L22N_3   NC
L7   IP_L23P_3   NC
L6   IP_L23N_3   NC
M4   IO_L24P_3   NC
M5   IO_L24N_3   NC
N1   IO_L25P_3   NC
N2   IO_L25N_3   NC
N3   IO_L26P_3   NC
N4   IO_L26N_3   NC
M8   IP_L27P_3   NC
P1   IO_L28P_3   NC
R1   IO_L28N_3   NC
P3   IO_L29P_3   NC
P4   IO_L29N_3   NC
R2   IO_L30P_3   NC
R3   IO_L30N_3   NC
M6   IP_L31P_3   NC
N7   IP_L31N_3   NC
T1   IO_L32P_3/VREF_3   NC
T2   IO_L32N_3   NC
T3   IO_L33P_3   NC
R4   IO_L33N_3   NC
U1   IO_L34P_3   NC
U3   IO_L34N_3   NC
P5   IP_L35P_3   NC
N6   IP_L35N_3   NC
R5   IO_L36P_3   NC
T4   IO_L36N_3   NC
V1   IO_L37P_3   NC
V2   IO_L37N_3   NC
W1   IO_L38P_3   NC
W2   IO_L38N_3   NC
P6   IP_L39P_3   NC
P7   IP_L39N_3/VREF_3   NC
U4   M1   LVCMOS25_S_12_TB_25
V4   M0   LVCMOS25_S_12_TB_25
P8   IP_2/VREF_2   NC
W3   M2   LVCMOS25_S_12_TB_25
Y2   CSO_B   LVCMOS25_S_12_TB_25
Y3   IO_L03P_2   NC
W4   IO_L03N_2   NC
T6   IO_L04P_2   NC
R7   IO_L04N_2   NC
V5   IO_L05P_2   NC
U5   IO_L05N_2   NC
T7   IO_L06P_2   NC
U6   IO_L06N_2   NC
T8   RDWR_B   LVCMOS25_S_12_TB_25
U7   VS2   LVCMOS25_S_12_TB_25
R8   2   NC
Y4   IO_L08P_2   NC
Y5   IO_L08N_2   NC
V6   VS1   LVCMOS25_S_12_TB_25
W6   VS0   LVCMOS25_S_12_TB_25
N9   IP_2/VREF_2   NC
Y6   IO_L10P_2   NC
T9   IO_L11P_2   NC
P9   2   NC
V7   D7   LVCMOS25_S_12_TB_25
W8   D6   LVCMOS25_S_12_TB_25
V8   IO_L13P_2   NC
V9   IO_L13N_2   NC
R10   2   NC
U10   D5   LVCMOS25_S_12_TB_25
T10   D4   LVCMOS25_S_12_TB_25
P10   IP_2/VREF_2   NC
V10   GCLK14   NC
V11   GCLK1   NC
T11   2   NC
U11   GCLK2   NC
V12   GCLK3   NC
T12   IO_L19P_2   NC
R12   IO_L19N_2   NC
P11   IP_2/VREF_2   NC
Y12   IO_L20P_2   NC
W12   MOSI/CSI_B   LVCMOS25_S_12_TB_25
Y13   IO_L21P_2   NC
W13   IO_L21N_2   NC
P12   2   NC
U13   AWAKE   NC
V13   DOUT   LVCMOS25_S_12_TB_25
T13   IO_L23P_2   NC
N12   IP_2/VREF_2   NC
Y14   INIT_B   LVCMOS25_S_12_TB_25
W14   D3   LVCMOS25_S_12_TB_25
V14   IO_L25P_2   NC
T14   IO_L25N_2   NC
P13   2   NC
Y15   D2   LVCMOS25_S_12_TB_25
V15   D1   LVCMOS25_S_12_TB_25
U15   IO_L27P_2   NC
T15   IO_L27N_2   NC
Y16   IO_L28P_2   NC
W16   IO_L28N_2   NC
V16   IO_L29P_2   NC
U16   IO_L29N_2   NC
Y17   IO_L30P_2   NC
Y18   IO_L30N_2   NC
V17   IO_L31P_2   NC
U17   IO_L31N_2   NC
R14   IP_2/VREF_2   NC
W18   D0/DIN/MISO   LVCMOS25_S_12_TB_25
Y19   CCLK   LVCMOS25_S_12_TB_25
W19   DONE   LVCMOS25_S_12_TB_25
R15   SUSPEND   LVCMOS25_S_12_TB_25
W20   HDC   LVCMOS25_S_12_TB_25
V20   LDC2   LVCMOS25_S_12_TB_25
V19   LDC1   LVCMOS25_S_12_TB_25
U18   LDC0   LVCMOS25_S_12_TB_25
T17   A0   LVCMOS25_S_12_TB_25
R16   A1   LVCMOS25_S_12_TB_25
P14   IP_L04P_1   NC
P15   IP_L04N_1/VREF_1   NC
T18   IO_L05P_1   NC
T20   IO_L05N_1   NC
U19   IO_L06P_1   NC
U20   IO_L06N_1   NC
P16   IO_L07P_1   NC
P17   IO_L07N_1   NC
N14   IP_1/VREF_1   NC
R18   IO_L08P_1   NC
R17   IO_L08N_1   NC
R19   IO_L09P_1   NC
R20   IO_L09N_1   NC
P18   IO_L10P_1   NC
P20   IO_L10N_1/VREF_1   NC
M16   IP_L11P_1   NC
M15   IP_L11N_1/VREF_1   NC
N15   A2   LVCMOS25_S_12_TB_25
N17   A3   LVCMOS25_S_12_TB_25
N18   A4   LVCMOS25_S_12_TB_25
N19   A5   LVCMOS25_S_12_TB_25
M17   A6   LVCMOS25_S_12_TB_25
M18   A7   LVCMOS25_S_12_TB_25
M14   IP_L15P_1/VREF_1   NC
M13   IP_L15N_1   NC
L15   A8   LVCMOS25_S_12_TB_25
L16   A9   LVCMOS25_S_12_TB_25
M19   RHCLK0   NC
M20   RHCLK1   NC
L19   RHCLK2   NC
L18   TRDY1/RHCLK3   NC
L14   IP_L19P_1   NC
L13   IP_L19N_1   NC
K18   RHCLK4   NC
L17   RHCLK5   NC
K20   IRDY1/RHCLK6   NC
J20   RHCLK7   NC
J19   A10   LVCMOS25_S_12_TB_25
J18   A11   LVCMOS25_S_12_TB_25
K15   IP_L23P_1/VREF_1   NC
K14   IP_L23N_1   NC
J17   IO_L24P_1   NC
K16   IO_L24N_1   NC
H19   A12   LVCMOS25_S_12_TB_25
H18   A13   LVCMOS25_S_12_TB_25
H20   A14   LVCMOS25_S_12_TB_25
G20   A15   LVCMOS25_S_12_TB_25
J16   IP_L27P_1   NC
J15   IP_L27N_1   NC
G18   IO_L28P_1   NC
H17   IO_L28N_1   NC
F20   A16   LVCMOS25_S_12_TB_25
F19   A17   LVCMOS25_S_12_TB_25
G17   A18   LVCMOS25_S_12_TB_25
F18   A19   LVCMOS25_S_12_TB_25
J14   IP_L31P_1/VREF_1   NC
J13   IP_L31N_1   NC
E20   IO_L32P_1   NC
E19   IO_L32N_1   NC
E18   IO_L33P_1   NC
F17   IO_L33N_1   NC
D20   IO_L34P_1   NC
D18   IO_L34N_1   NC
H15   IP_L35P_1   NC
H14   IP_L35N_1   NC
G16   A20   LVCMOS25_S_12_TB_25
F16   A21   LVCMOS25_S_12_TB_25
C20   A22   LVCMOS25_S_12_TB_25
C19   A23   LVCMOS25_S_12_TB_25
B20   A24   LVCMOS25_S_12_TB_25
B19   A25   LVCMOS25_S_12_TB_25
G15   IP_L39P_1/VREF_1   NC
G14   IP_L39N_1   NC
E17   TDO   LVCMOS25_S_12_TB_25
A19   TCK   LVCMOS25_S_12_TB_25
B18   IO_L01P_0   NC
A18   IO_L01N_0   NC
F14   0   NC
D17   IO_L02P_0/VREF_0   NC
C17   IO_L02N_0   NC
D16   IO_L03P_0   NC
E15   IO_L03N_0   NC
B17   IO_L04P_0/VREF_0   NC
A17   IO_L04N_0   NC
C16   IO_L05P_0   NC
A16   IO_L05N_0   NC
G13   0   NC
D15   IO_L06P_0   NC
C15   IO_L06N_0   NC
C14   IO_L07P_0   NC
A14   IO_L07N_0   NC
E14   0   NC
B15   IO_L08P_0   NC
A15   IO_L08N_0   NC
E13   IO_L09P_0   NC
F13   IO_L09N_0   NC
G12   0   NC
D14   IO_L10P_0   NC
C13   IO_L10N_0/VREF_0   NC
B13   IO_L11P_0   NC
C12   IO_L11N_0   NC
H12   0   NC
D12   IO_L12P_0   NC
F12   IO_L12N_0   NC
B12   IO_L13P_0   NC
A12   IO_L13N_0   NC
H11   0   NC
B11   IO_L14P_0   NC
C11   IO_L14N_0   NC
D11   GCLK4   NC
G11   IP_0/VREF_0   NC
A10   GCLK6   NC
C10   GCLK7   NC
D10   GCLK8   NC
E10   GCLK9   NC
F11   0   NC
A9   GCLK10   NC
A8   GCLK11   NC
B9   IO_L19P_0   NC
C9   IO_L19N_0   NC
H10   0   NC
B8   IO_L20P_0   NC
C8   IO_L20N_0   NC
C7   IO_L21P_0   NC
D8   IO_L21N_0   NC
G10   0   NC
E9   IO_L22P_0   NC
F9   IO_L22N_0/VREF_0   NC
E8   IO_L23P_0   NC
F8   IO_L23N_0   NC
H9   0   NC
B7   IO_L24P_0   NC
A7   IO_L24N_0   NC
A6   IO_L25P_0   NC
C6   IO_L25N_0   NC
G9   0   NC
A5   IO_L26P_0   NC
B5   IO_L26N_0   NC
E7   IO_L27P_0   NC
F7   IO_L27N_0   NC
C5   IO_L28P_0   NC
D6   IO_L28N_0   NC
A4   IO_L29P_0   NC
C4   IO_L29N_0   NC
A3   IO_L30P_0   NC
B3   IO_L30N_0   NC
E6   IO_L31P_0   NC
F6   IO_L31N_0   NC
G8   0   NC
A2   IO_L32P_0/VREF_0   NC
B2   PUDC_B   LVCMOS25_S_12_TB_25
D5   PROG_B   LVCMOS25_S_12_TB_25
A1   GND   GND
A11   GND   GND
A20   GND   GND
B14   GND   GND
B6   GND   GND
C18   GND   GND
C3   GND   GND
D9   GND   GND
E12   GND   GND
E5   GND   GND
F15   GND   GND
G19   GND   GND
G2   GND   GND
H13   GND   GND
H8   GND   GND
J11   GND   GND
J9   GND   GND
K1   GND   GND
K10   GND   GND
K12   GND   GND
K17   GND   GND
L11   GND   GND
L20   GND   GND
L4   GND   GND
L9   GND   GND
M10   GND   GND
M12   GND   GND
N11   GND   GND
N13   GND   GND
N8   GND   GND
P19   GND   GND
P2   GND   GND
R6   GND   GND
R9   GND   GND
T16   GND   GND
U12   GND   GND
V18   GND   GND
V3   GND   GND
W15   GND   GND
W7   GND   GND
Y1   GND   GND
Y10   GND   GND
Y20   GND   GND
A13   VCCAUX   POWER
E16   VCCAUX   POWER
H1   VCCAUX   POWER
K13   VCCAUX   POWER
L8   VCCAUX   POWER
N20   VCCAUX   POWER
T5   VCCAUX   POWER
Y8   VCCAUX   POWER
J10   VCCINT   POWER
J12   VCCINT   POWER
K11   VCCINT   POWER
K9   VCCINT   POWER
L10   VCCINT   POWER
L12   VCCINT   POWER
M11   VCCINT   POWER
M9   VCCINT   POWER
N10   VCCINT   POWER
B10   VCCO_0   POWER
B16   VCCO_0   POWER
B4   VCCO_0   POWER
D13   VCCO_0   POWER
D7   VCCO_0   POWER
F10   VCCO_0   POWER
D19   VCCO_1   POWER
H16   VCCO_1   POWER
K19   VCCO_1   POWER
N16   VCCO_1   POWER
T19   VCCO_1   POWER
R11   VCCO_2   POWER
U14   VCCO_2   POWER
U8   VCCO_2   POWER
W11   VCCO_2   POWER
W17   VCCO_2   POWER
W5   VCCO_2   POWER
E2   VCCO_3   POWER
H5   VCCO_3   POWER
L2   VCCO_3   POWER
N5   VCCO_3   POWER
U2   VCCO_3   POWER
| Models and submodels in the file (2): LVCMOS25_S_12_LR_25 (I/O), LVCMOS25_S_12_TB_25 (I/O)
